* Blaze CircuitLab experimental SPICE export
* Current Source Series Loop
I1 0 N1 0.01
R1 N1 N2 330
R2 N2 0 470
.tran 0.001 0.1
.end
